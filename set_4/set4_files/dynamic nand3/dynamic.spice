* SPICE3 file created from dynamic.ext - technology: scmos
.INC models_0.25.sp
.option scale=0.0625u
.param t=1000n

M1000 VDD SRAM_6t_0/a_6_15# SRAM_6t_0/a_4_34# VDD pfet w=4 l=2
+  ad=810 pd=674 as=20 ps=18
M1001 SRAM_6t_0/a_4_34# SRAM_6t_0/a_6_15# GND GND nfet w=4 l=2
+  ad=53 pd=40 as=436 ps=379
M1002 VDD SRAM_6t_0/a_4_34# SRAM_6t_0/a_6_15# VDD pfet w=4 l=2
+  ad=0 pd=0 as=20 ps=18
M1003 GND SRAM_6t_0/a_4_34# SRAM_6t_0/a_6_15# GND nfet w=4 l=2
+  ad=0 pd=0 as=53 ps=40
M1004 SRAM_6t_0/a_4_34# WL0 BL GND nfet w=3 l=2
+  ad=0 pd=0 as=200 ps=176
M1005 SRAM_6t_0/a_6_15# WL0 notBL GND nfet w=3 l=2
+  ad=0 pd=0 as=200 ps=176
M1006 notQ7 WL7 notBL GND nfet w=3 l=2
+  ad=53 pd=40 as=0 ps=0
M1007 OUT1 Clk VDD VDD pfet w=4 l=2
+  ad=20 pd=18 as=0 ps=0
M1008 a_n12_n168# Clk GND GND nfet w=3 l=2
+  ad=38 pd=36 as=0 ps=0
M1009 GND Q6 notQ6 GND nfet w=4 l=2
+  ad=0 pd=0 as=53 ps=40
M1010 WL0 OUT0 GND GND nfet w=3 l=2
+  ad=19 pd=18 as=0 ps=0
M1011 notA0 A0 GND w_n41_n46# nfet w=3 l=2
+  ad=19 pd=18 as=0 ps=0
M1012 Q5 notQ5 GND GND nfet w=4 l=2
+  ad=53 pd=40 as=0 ps=0
M1013 GND Q4 notQ4 GND nfet w=4 l=2
+  ad=0 pd=0 as=53 ps=40
M1014 WL7 OUT7 GND GND nfet w=3 l=2
+  ad=19 pd=18 as=0 ps=0
M1015 Q5 WL5 BL GND nfet w=3 l=2
+  ad=0 pd=0 as=0 ps=0
M1016 OUT4 notA0 a_129_0# GND nfet w=3 l=2
+  ad=19 pd=18 as=28 ps=24
M1017 WL5 OUT5 GND GND nfet w=3 l=2
+  ad=19 pd=18 as=0 ps=0
M1018 Q4 WL4 BL GND nfet w=3 l=2
+  ad=53 pd=40 as=0 ps=0
M1019 VDD notQ2 Q2 VDD pfet w=4 l=2
+  ad=0 pd=0 as=20 ps=18
M1020 OUT3 A0 a_14_n168# GND nfet w=3 l=2
+  ad=19 pd=18 as=28 ps=24
M1021 notQ3 WL3 notBL GND nfet w=3 l=2
+  ad=53 pd=40 as=0 ps=0
M1022 OUT5 A0 a_129_n56# GND nfet w=3 l=2
+  ad=19 pd=18 as=28 ps=24
M1023 Q7 WL7 BL GND nfet w=3 l=2
+  ad=53 pd=40 as=0 ps=0
M1024 a_129_n168# A1 a_119_n168# GND nfet w=3 l=2
+  ad=28 pd=24 as=28 ps=24
M1025 GND Q3 notQ3 GND nfet w=4 l=2
+  ad=0 pd=0 as=0 ps=0
M1026 OUT3 Clk VDD VDD pfet w=4 l=2
+  ad=20 pd=18 as=0 ps=0
M1027 GND Q2 notQ2 GND nfet w=4 l=2
+  ad=0 pd=0 as=53 ps=40
M1028 VDD Q2 notQ2 VDD pfet w=4 l=2
+  ad=0 pd=0 as=20 ps=18
M1029 notA0 A0 VDD VDD pfet w=6 l=2
+  ad=30 pd=22 as=0 ps=0
M1030 WL3 OUT3 GND GND nfet w=3 l=2
+  ad=19 pd=18 as=0 ps=0
M1031 WL7 OUT7 VDD Vdd pfet w=6 l=2
+  ad=30 pd=22 as=0 ps=0
M1032 VDD notQ5 Q5 VDD pfet w=4 l=2
+  ad=0 pd=0 as=20 ps=18
M1033 Q1 notQ1 GND GND nfet w=4 l=2
+  ad=53 pd=40 as=0 ps=0
M1034 WL5 OUT5 VDD Vdd pfet w=6 l=2
+  ad=30 pd=22 as=0 ps=0
M1035 a_4_n168# notA2 a_n12_n168# GND nfet w=3 l=2
+  ad=28 pd=24 as=0 ps=0
M1036 Q7 notQ7 GND GND nfet w=4 l=2
+  ad=0 pd=0 as=0 ps=0
M1037 OUT6 notA0 a_129_n112# GND nfet w=3 l=2
+  ad=19 pd=18 as=28 ps=24
M1038 OUT4 Clk VDD VDD pfet w=4 l=2
+  ad=20 pd=18 as=0 ps=0
M1039 notQ6 WL6 notBL GND nfet w=3 l=2
+  ad=0 pd=0 as=0 ps=0
M1040 Q3 WL3 BL GND nfet w=3 l=2
+  ad=53 pd=40 as=0 ps=0
M1041 a_n12_n112# Clk GND GND nfet w=3 l=2
+  ad=38 pd=36 as=0 ps=0
M1042 GND Q5 notQ5 GND nfet w=4 l=2
+  ad=0 pd=0 as=53 ps=40
M1043 a_14_n168# A1 a_4_n168# GND nfet w=3 l=2
+  ad=0 pd=0 as=0 ps=0
M1044 WL2 OUT2 VDD Vdd pfet w=6 l=2
+  ad=30 pd=22 as=0 ps=0
M1045 VDD Q5 notQ5 VDD pfet w=4 l=2
+  ad=0 pd=0 as=20 ps=18
M1046 notQ1 WL1 notBL GND nfet w=3 l=2
+  ad=53 pd=40 as=0 ps=0
M1047 VDD notQ7 Q7 VDD pfet w=4 l=2
+  ad=0 pd=0 as=20 ps=18
M1048 VDD notQ4 Q4 VDD pfet w=4 l=2
+  ad=0 pd=0 as=20 ps=18
M1049 a_14_0# notA1 a_4_0# GND nfet w=3 l=2
+  ad=28 pd=24 as=28 ps=24
M1050 OUT6 Clk VDD VDD pfet w=4 l=2
+  ad=20 pd=18 as=0 ps=0
M1051 a_119_n168# A2 a_103_n168# GND nfet w=3 l=2
+  ad=0 pd=0 as=38 ps=36
M1052 WL6 OUT6 GND GND nfet w=3 l=2
+  ad=19 pd=18 as=0 ps=0
M1053 notA2 A2 GND w_n43_n167# nfet w=3 l=2
+  ad=19 pd=18 as=0 ps=0
M1054 a_129_n56# notA1 a_119_n56# GND nfet w=3 l=2
+  ad=0 pd=0 as=28 ps=24
M1055 WL3 OUT3 VDD Vdd pfet w=6 l=2
+  ad=30 pd=22 as=0 ps=0
M1056 a_103_n168# Clk GND GND nfet w=3 l=2
+  ad=0 pd=0 as=0 ps=0
M1057 VDD Q7 notQ7 VDD pfet w=4 l=2
+  ad=0 pd=0 as=20 ps=18
M1058 WL4 OUT4 GND GND nfet w=3 l=2
+  ad=19 pd=18 as=0 ps=0
M1059 Q4 notQ4 GND GND nfet w=4 l=2
+  ad=0 pd=0 as=0 ps=0
M1060 OUT2 notA0 a_14_n112# GND nfet w=3 l=2
+  ad=19 pd=18 as=28 ps=24
M1061 notQ2 WL2 notBL GND nfet w=3 l=2
+  ad=0 pd=0 as=0 ps=0
M1062 Q1 WL1 BL GND nfet w=3 l=2
+  ad=0 pd=0 as=0 ps=0
M1063 WL1 OUT1 GND GND nfet w=3 l=2
+  ad=19 pd=18 as=0 ps=0
M1064 VDD Q4 notQ4 VDD pfet w=4 l=2
+  ad=0 pd=0 as=20 ps=18
M1065 Q6 WL6 BL GND nfet w=3 l=2
+  ad=53 pd=40 as=0 ps=0
M1066 a_129_n112# A1 a_119_n112# GND nfet w=3 l=2
+  ad=0 pd=0 as=28 ps=24
M1067 OUT2 Clk VDD VDD pfet w=4 l=2
+  ad=20 pd=18 as=0 ps=0
M1068 a_103_n56# Clk GND GND nfet w=3 l=2
+  ad=38 pd=36 as=0 ps=0
M1069 OUT0 notA0 a_14_0# GND nfet w=3 l=2
+  ad=19 pd=18 as=0 ps=0
M1070 VDD notQ3 Q3 VDD pfet w=4 l=2
+  ad=0 pd=0 as=20 ps=18
M1071 GND Q1 notQ1 GND nfet w=4 l=2
+  ad=0 pd=0 as=0 ps=0
M1072 a_4_n56# notA2 a_n12_n56# GND nfet w=3 l=2
+  ad=28 pd=24 as=38 ps=36
M1073 notA1 A1 VDD VDD pfet w=6 l=2
+  ad=30 pd=22 as=0 ps=0
M1074 OUT0 Clk VDD VDD pfet w=4 l=2
+  ad=20 pd=18 as=0 ps=0
M1075 WL2 OUT2 GND GND nfet w=3 l=2
+  ad=19 pd=18 as=0 ps=0
M1076 OUT1 A0 a_14_n56# GND nfet w=3 l=2
+  ad=19 pd=18 as=28 ps=24
M1077 VDD notQ6 Q6 VDD pfet w=4 l=2
+  ad=0 pd=0 as=20 ps=18
M1078 Q6 notQ6 GND GND nfet w=4 l=2
+  ad=0 pd=0 as=0 ps=0
M1079 a_4_0# notA2 a_n12_0# GND nfet w=3 l=2
+  ad=0 pd=0 as=38 ps=36
M1080 VDD Q3 notQ3 VDD pfet w=4 l=2
+  ad=0 pd=0 as=20 ps=18
M1081 a_4_n112# notA2 a_n12_n112# GND nfet w=3 l=2
+  ad=28 pd=24 as=0 ps=0
M1082 notA1 A1 GND w_n41_n111# nfet w=3 l=2
+  ad=19 pd=18 as=0 ps=0
M1083 OUT7 Clk VDD VDD pfet w=4 l=2
+  ad=20 pd=18 as=0 ps=0
M1084 a_119_0# A2 a_103_0# GND nfet w=3 l=2
+  ad=28 pd=24 as=38 ps=36
M1085 a_103_0# Clk GND GND nfet w=3 l=2
+  ad=0 pd=0 as=0 ps=0
M1086 GND Q7 notQ7 GND nfet w=4 l=2
+  ad=0 pd=0 as=0 ps=0
M1087 Q3 notQ3 GND GND nfet w=4 l=2
+  ad=0 pd=0 as=0 ps=0
M1088 a_n12_n56# Clk GND GND nfet w=3 l=2
+  ad=0 pd=0 as=0 ps=0
M1089 Q2 WL2 BL GND nfet w=3 l=2
+  ad=53 pd=40 as=0 ps=0
M1090 VDD Q6 notQ6 VDD pfet w=4 l=2
+  ad=0 pd=0 as=20 ps=18
M1091 a_119_n56# A2 a_103_n56# GND nfet w=3 l=2
+  ad=0 pd=0 as=0 ps=0
M1092 VDD notQ1 Q1 VDD pfet w=4 l=2
+  ad=0 pd=0 as=20 ps=18
M1093 a_14_n112# A1 a_4_n112# GND nfet w=3 l=2
+  ad=0 pd=0 as=0 ps=0
M1094 WL1 OUT1 VDD Vdd pfet w=6 l=2
+  ad=30 pd=22 as=0 ps=0
M1095 WL4 OUT4 VDD Vdd pfet w=6 l=2
+  ad=30 pd=22 as=0 ps=0
M1096 WL0 OUT0 VDD Vdd pfet w=6 l=2
+  ad=30 pd=22 as=0 ps=0
M1097 OUT5 Clk VDD VDD pfet w=4 l=2
+  ad=20 pd=18 as=0 ps=0
M1098 notQ4 WL4 notBL GND nfet w=3 l=2
+  ad=0 pd=0 as=0 ps=0
M1099 a_119_n112# A2 a_103_n112# GND nfet w=3 l=2
+  ad=0 pd=0 as=38 ps=36
M1100 a_103_n112# Clk GND GND nfet w=3 l=2
+  ad=0 pd=0 as=0 ps=0
M1101 a_n12_0# Clk GND GND nfet w=3 l=2
+  ad=0 pd=0 as=0 ps=0
M1102 VDD Q1 notQ1 VDD pfet w=4 l=2
+  ad=0 pd=0 as=20 ps=18
M1103 a_129_0# notA1 a_119_0# GND nfet w=3 l=2
+  ad=0 pd=0 as=0 ps=0
M1104 Q2 notQ2 GND GND nfet w=4 l=2
+  ad=0 pd=0 as=0 ps=0
M1105 WL6 OUT6 VDD Vdd pfet w=6 l=2
+  ad=30 pd=22 as=0 ps=0
M1106 notQ5 WL5 notBL GND nfet w=3 l=2
+  ad=0 pd=0 as=0 ps=0
M1107 notA2 A2 VDD VDD pfet w=6 l=2
+  ad=30 pd=22 as=0 ps=0
M1108 OUT7 A0 a_129_n168# GND nfet w=3 l=2
+  ad=19 pd=18 as=0 ps=0
M1109 a_14_n56# notA1 a_4_n56# GND nfet w=3 l=2
+  ad=0 pd=0 as=0 ps=0
C0 VDD notA0 18.23fF
C1 GND WL0 9.61fF
C2 GND notQ4 4.36fF
C3 VDD notQ6 3.90fF
C4 GND Q5 7.00fF
C5 GND VDD 5.64fF
C6 GND notQ3 4.36fF
C7 VDD notBL 5.75fF
C8 VDD Q7 3.39fF
C9 VDD Clk 61.82fF
C10 GND WL4 9.61fF
C11 GND WL5 9.61fF
C12 SRAM_6t_0/a_4_34# VDD 3.39fF
C13 VDD A2 18.69fF
C14 GND WL6 9.61fF
C15 VDD Q2 3.39fF
C16 GND notQ1 4.36fF
C17 GND WL2 9.61fF
C18 GND notA1 17.64fF
C19 GND WL1 9.61fF
C20 VDD notQ4 3.90fF
C21 GND Q6 7.00fF
C22 VDD Q5 3.55fF
C23 VDD notQ3 3.90fF
C24 GND BL 19.26fF
C25 VDD notQ1 5.12fF
C26 GND notQ7 4.36fF
C27 notA0 OUT5 3.56fF
C28 VDD notA1 8.71fF
C29 GND SRAM_6t_0/a_6_15# 4.36fF
C30 GND A0 16.69fF
C31 GND notQ2 4.36fF
C32 GND Q4 7.00fF
C33 VDD Q6 3.39fF
C34 OUT4 notA0 3.51fF
C35 GND Q3 7.00fF
C36 GND notQ5 4.36fF
C37 GND WL3 9.61fF
C38 VDD BL 6.35fF
C39 GND Q1 7.00fF
C40 VDD notQ7 3.90fF
C41 notA0 OUT1 4.63fF
C42 VDD OUT0 7.24fF
C43 GND notA2 8.80fF
C44 GND A1 12.78fF
C45 SRAM_6t_0/a_6_15# VDD 3.90fF
C46 VDD A0 17.60fF
C47 VDD notQ2 3.90fF
C48 VDD Q4 3.39fF
C49 GND notA0 9.18fF
C50 VDD Q3 3.39fF
C51 OUT0 notA1 3.69fF
C52 GND notQ6 4.36fF
C53 VDD OUT4 6.82fF
C54 VDD notQ5 5.12fF
C55 GND notBL 19.86fF
C56 VDD Q1 3.55fF
C57 GND Q7 7.00fF
C58 GND Clk 18.60fF
C59 VDD notA2 6.89fF
C60 VDD A1 51.05fF
C61 GND SRAM_6t_0/a_4_34# 7.00fF
C62 GND A2 10.40fF
C63 GND Q2 7.00fF
C64 GND WL7 9.61fF
C65 WL7 Vdd 4.59fF
C66 notQ7 Vdd 4.05fF
C67 OUT7 Vdd 3.20fF
C68 WL6 Vdd 2.73fF
C69 WL3 Vdd 4.59fF
C70 notQ3 Vdd 4.05fF
C71 OUT3 Vdd 4.14fF
C72 notQ6 Vdd 4.05fF
C73 OUT6 Vdd 3.95fF
C74 WL2 Vdd 4.59fF
C75 OUT2 Vdd 4.89fF
C76 notQ2 Vdd 4.05fF
C77 BL Vdd 2.17fF
C78 notBL Vdd 3.48fF
C79 A1 Vdd 71.19fF
C80 WL5 Vdd 4.59fF
C81 OUT5 Vdd 3.57fF
C82 WL1 Vdd 4.59fF
C83 OUT1 Vdd 4.89fF
C84 notQ1 Vdd 2.82fF
C85 A0 Vdd 112.34fF
C86 A2 Vdd 59.18fF
C87 notA0 Vdd 37.44fF
C88 notA1 Vdd 54.45fF
C89 notA2 Vdd 21.35fF
C90 WL4 Vdd 4.59fF
C91 OUT0 Vdd 9.96fF
C92 Clk Vdd 52.84fF
C93 WL0 Vdd 4.75fF
C94 SRAM_6t_0/a_6_15# Vdd 4.77fF
C95 SRAM_6t_0/a_4_34# Vdd 2.32fF
C96 GND Vdd 55.88fF
C97 VDD Vdd 257.51fF

*---- Actual test ----
Vdd VDD 0 DC 2.5
*VA0 A0 0 PULSE (0 2.5 {t} 1p 1p {t} {2*t})
*VA1 A1 0 PULSE (0 2.5 {2*t} 1p 1p {2*t} {4*t})
*VA2 A2 0 PULSE (0 2.5 {4*t} 1p 1p {4*t} {8*t})
VClk Clk 0 PULSE (0 2.5 {8*t} 1p 1p {8*t} {16*t})

*--- SRAM 0
*VA2 A2 0 DC 0
*VA1 A1 0 DC 0
*VA0 A0 0 DC 0

*--- SRAM 1
*VA2 A2 0 DC 0
*VA1 A1 0 DC 0
*VA0 A0 0 DC 2.5

*--- SRAM 2
VA2 A2 0 DC 0
VA1 A1 0 DC 2.5
VA0 A0 0 DC 0

***TO SRAM 2 WRITE 1 AND READ IT LATER
VBL BL 0 PWL(
+    0n 0
+    6000n 0
+    6001n 2.5   16000n 2.2
+    22000n 2.2   22000n 2.5
+    29000 0    32000n 0
+)

VnBL notBL 0 PWL(
+    0n 0
+    22000n 0  22001n 2.5
+    29000n 0     32000n 0
+)
.ic v(Q2) 0

*--- SRAM 3
*VA2 A2 0 DC 0
*VA1 A1 0 DC 2.5
*VA0 A0 0 DC 2.5

*--- SRAM 4
*VA2 A2 0 DC 2.5
*VA1 A1 0 DC 0
*VA0 A0 0 DC 0

*--- SRAM 5
*VA2 A2 0 DC 2.5
*VA1 A1 0 DC 0
*VA0 A0 0 DC 2.5

*--- SRAM 6
*VA2 A2 0 DC 2.5
*VA1 A1 0 DC 2.5
*VA0 A0 0 DC 0

*--- SRAM 7
*VA2 A2 0 DC 2.5
*VA1 A1 0 DC 2.5
*VA0 A0 0 DC 2.5

.tran 0.001 32000n
.control
    run
    plot v(WL0) v(WL1)+4 v(WL2)+8 v(WL3)+12 v(WL4)+16 v(WL5)+20 v(WL6)+24 v(WL7)+28 v(Clk) +32
    plot v(A0) v(A1)+4 v(A2)+8 v(Clk)+12
    plot v(BL) v(notBL)
    *plot v(Clk) v(A0)+4 v(A1)+8 v(A2)+12 v(WL0)+16
    *plot v(Clk) v(A0)+4 v(A1)+8 v(A2)+12 v(WL1)+16
    plot v(Clk) v(WL2)+4 v(Q2)+8 v(notQ2)+12
    *plot v(Clk) v(A0)+4 v(A1)+8 v(A2)+12 v(WL3)+16
    *plot v(Clk) v(A0)+4 v(A1)+8 v(A2)+12 v(WL4)+16
    *plot v(Clk) v(A0)+4 v(A1)+8 v(A2)+12 v(WL5)+16
    *plot v(Clk) v(A0)+4 v(A1)+8 v(A2)+12 v(WL6)+16
    *plot v(Clk) v(A0)+4 v(A1)+8 v(A2)+12 v(WL7)+16
.endc
