*Askhsh 1 part B PMOS
.include models_0.25.sp

.param VDD=2.5
.param Cval=0.1p

*d = drain, g = gate, s = 0(ground)
Vdd vdd 0 DC {VDD}
C d 0 {Cval}

*Empty capacitor
.ic V(d)= 0

*PMOS
M1 d g vdd vdd CMOSP w=3u l=2u

Vg g 0 DC 0

.tran 0.1n 50n
*------MEASURMENTS------*
* t_half = ln(2)*Req*C <=> Req = t_half/(ln2*C)
* Measure time when Vd reaches 50% VDD
.meas tran t_half WHEN V(d)= VDD/2 RISE=1

*Calculate Req
.meas tran Req PARAM  t_half/(0.69*Cval)

* Print results in console
.PROBE V(d) V(g) V(vdd)
.end
