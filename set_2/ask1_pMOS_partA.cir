* Askhsh 1 PMOS
.include models_0.25.sp

*(d g s b)
Mp 2 1 3 3 CMOSP w=3u l=2u

Vss 3 0 DC 2.5

Vgs 1 3 DC 0
Vds 2 3 DC 0

.DC Vds -2.5 0 0.05 Vgs -2.5 0 0.25
.PROBE ID(Mp)
.END
