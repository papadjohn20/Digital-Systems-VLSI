* SPICE3 file created from xnor.ext - technology: scmos
.INC models_0.25.sp
.option scale=0.125u
.param t=1000n

*--- A ---
*PMOS
M1011 a_n9_46# A OUT VDD CMOSP w=19 l=2
+  ad=0 pd=0 as=0 ps=0
M1005 VDD A notA VDD CMOSP w=19 l=2
+  ad=0 pd=0 as=65 ps=48
*NMOS
M1004 OUT A a_14_0# GND CMOSN w=8 l=2
+  ad=64 pd=52 as=16 ps=20
M1001 GND A notA GND CMOSN w=8 l=2
+  ad=0 pd=0 as=32 ps=26

M d g s b

*--- B ---
*PMOS
M1003 a_n9_46# B VDD VDD CMOSP w=19 l=2
+  ad=244 pd=146 as=0 ps=0
M1002 notB B VDD VDD CMOSP w=19 l=2
+  ad=65 pd=48 as=244 ps=146
*NMOS
M1009 GND B a_2_0# GND CMOSN w=8 l=2
+  ad=0 pd=0 as=16 ps=20
M1000 notB B GND GND CMOSN w=8 l=2
+  ad=32 pd=26 as=112 ps=80

*--- notA ---
*PMOS
M1008 VDD notA a_n9_46# VDD CMOSP w=19 l=2
+  ad=0 pd=0 as=0 ps=0
*NMOS
M1010 a_2_0# notA OUT GND CMOSN w=8 l=2
+  ad=0 pd=0 as=0 ps=0

*--- notB ---
*PMOS
M1006 OUT notB a_n9_46# VDD CMOSP w=19 l=2
+  ad=114 pd=50 as=0 ps=0
*NMOS
M1007 a_14_0# notB GND GND CMOSN w=8 l=2
+  ad=0 pd=0 as=0 ps=0

C0 GND notA 2.08fF
C1 GND OUT 4.32fF
C2 GND A 2.71fF
C3 VDD A 2.39fF
C4 GND B 2.39fF
C5 VDD B 2.39fF
C6 VDD a_n9_46# 2.63fF
C7 OUT 0 16.17fF
C8 notB 0 20.48fF
C9 notA 0 21.13fF

Vdd VDD 0 DC 2.5
VB B 0 PULSE (0 2.5 {t} 1p 1p {t} {2*t})
VA A 0 PULSE (0 2.5 {2*t} 1p 1p {2*t} {4*t})

.tran 0.001 {4*t}
.control
    run
    plot v(out) v(B)+4 v(A)+8 V(notB)+12 V(notA)+15
.endc

.end
